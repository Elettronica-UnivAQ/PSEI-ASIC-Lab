* NGSPICE file created from buffer_parax.ext - technology: sky130A

.subckt buffer_parax VDD GND IN OUT
X0 OUT.t3 out1.t3 VDD.t10 VDD.t9 sky130_fd_pr__pfet_01v8 ad=0.33 pd=2.33 as=0.33 ps=2.33 w=2 l=0.15
X1 out1.t1 IN.t0 GND.t1 GND.t0 sky130_fd_pr__nfet_01v8 ad=0.29 pd=2.58 as=0.29 ps=2.58 w=1 l=0.15
X2 OUT.t5 out1.t4 GND.t4 GND.t2 sky130_fd_pr__nfet_01v8 ad=0.33 pd=2.33 as=0.62 ps=4.62 w=2 l=0.15
X3 out1.t2 IN.t1 VDD.t2 VDD.t0 sky130_fd_pr__pfet_01v8 ad=0.165 pd=1.33 as=0.31 ps=2.62 w=1 l=0.15
X4 VDD.t8 out1.t5 OUT.t2 VDD.t7 sky130_fd_pr__pfet_01v8 ad=0.62 pd=4.62 as=0.33 ps=2.33 w=2 l=0.15
X5 VDD.t1 IN.t2 out1.t0 VDD.t0 sky130_fd_pr__pfet_01v8 ad=0.31 pd=2.62 as=0.165 ps=1.33 w=1 l=0.15
X6 GND.t3 out1.t6 OUT.t4 GND.t2 sky130_fd_pr__nfet_01v8 ad=0.62 pd=4.62 as=0.33 ps=2.33 w=2 l=0.15
X7 OUT.t1 out1.t7 VDD.t6 VDD.t5 sky130_fd_pr__pfet_01v8 ad=0.33 pd=2.33 as=0.62 ps=4.62 w=2 l=0.15
X8 VDD.t4 out1.t8 OUT.t0 VDD.t3 sky130_fd_pr__pfet_01v8 ad=0.33 pd=2.33 as=0.33 ps=2.33 w=2 l=0.15
R0 inverterx4_0.XM2.G2 out1.t8 547.24
R1 inverterx4_0.XM2.G0 out1.t5 547.24
R2 inverterx4_0.XM2.G1 out1.t3 547.24
R3 inverterx4_0.XM2.G3 out1.t7 547.24
R4 inverterx4_0.XM1.G0 out1.t6 532.78
R5 inverterx4_0.XM1.G1 out1.t4 532.78
R6 inverter_0.XM2.S1 out1.n7 195
R7 inverter_0.sky130_fd_pr__nfet_01v8_VLDN8W_0.D out1.t1 79.0672
R8 out1.n7 out1.t0 32.5055
R9 out1.n7 out1.t2 32.5055
R10 out1.n3 inverterx4_0.XM1.G1 27.1093
R11 out1.n0 inverterx4_0.XM2.G3 14.7491
R12 out1.n1 inverterx4_0.XM2.G0 14.3831
R13 out1.n0 inverterx4_0.XM2.G1 14.3577
R14 out1.n2 inverterx4_0.XM2.G2 14.3503
R15 out1.n3 inverterx4_0.XM1.G0 14.3486
R16 out1.n1 out1.n0 12.8155
R17 inverter_0.XM2.S1 out1.n6 9.99705
R18 out1.n6 inverter_0.sky130_fd_pr__nfet_01v8_VLDN8W_0.D 9.82229
R19 out1.n6 inverter_0.OUT 5.34538
R20 inverterx4_0.IN out1.n4 5.10925
R21 out1.n4 out1.n2 0.722261
R22 out1.n4 out1.n3 0.597261
R23 out1.n2 out1.n1 0.372647
R24 out1.n5 inverter_0.OUT 0.124875
R25 out1.n5 inverterx4_0.IN 0.0937836
R26 inverter_0.OUT out1.n5 0.0626891
R27 VDD.n17 VDD.n14 2311.76
R28 VDD.n19 VDD.n14 2311.76
R29 VDD.n17 VDD.n16 2311.76
R30 VDD.n19 VDD.n16 2311.76
R31 VDD.n9 VDD.n3 1620
R32 VDD.n7 VDD.n6 1620
R33 VDD.n6 VDD.n5 391.827
R34 VDD.n9 VDD.n8 391.827
R35 VDD VDD.n15 246.589
R36 VDD.n15 VDD.n13 246.589
R37 VDD.n0 VDD.t2 237.197
R38 VDD VDD.t1 227.506
R39 VDD.n20 VDD 214.661
R40 VDD.n20 VDD.n13 214.661
R41 VDD.t7 VDD.n14 206.778
R42 VDD.t5 VDD.n16 206.778
R43 VDD VDD.n2 172.8
R44 VDD.n4 VDD.n2 172.8
R45 VDD.n4 VDD.n1 155.815
R46 VDD.n10 VDD 153.827
R47 VDD.n22 VDD.t6 120.885
R48 VDD VDD.t8 113.754
R49 VDD.t9 VDD.t7 108.832
R50 VDD.t3 VDD.t5 108.832
R51 VDD VDD.n21 97.5005
R52 VDD.n18 VDD.t9 54.4158
R53 VDD.n18 VDD.t3 54.4158
R54 VDD VDD.n9 46.2505
R55 VDD.n6 VDD.n4 46.2505
R56 VDD.n7 VDD.n2 30.8338
R57 VDD.n3 VDD.n1 30.8338
R58 VDD VDD.n19 26.4291
R59 VDD.n19 VDD.n18 26.4291
R60 VDD.n17 VDD.n13 26.4291
R61 VDD.n18 VDD.n17 26.4291
R62 VDD.n16 VDD.n15 23.1255
R63 VDD.n20 VDD.n14 23.1255
R64 VDD.n5 VDD.n3 22.9401
R65 VDD.n8 VDD.n7 22.9401
R66 VDD.n21 VDD.t10 16.253
R67 VDD.n21 VDD.t4 16.253
R68 VDD.n0 VDD 9.31668
R69 VDD.n8 VDD.t0 7.4586
R70 VDD.n5 VDD.t0 7.4586
R71 VDD.n22 VDD 6.7647
R72 VDD.n23 VDD 6.75927
R73 VDD.n12 VDD.n11 5.13584
R74 VDD.n25 VDD.n24 5.05708
R75 VDD.n11 VDD.n10 3.8255
R76 VDD.n25 VDD 1.93151
R77 VDD.n24 VDD.n20 1.92469
R78 VDD.n26 VDD 1.13352
R79 VDD.n10 VDD.n1 1.0245
R80 VDD.n26 VDD 0.59542
R81 VDD.n28 VDD 0.467078
R82 VDD.n23 VDD.n22 0.375086
R83 VDD.n24 VDD.n23 0.292966
R84 VDD VDD.n28 0.244898
R85 VDD.n11 VDD.n0 0.153744
R86 VDD.n27 VDD.n12 0.111125
R87 VDD VDD.n25 0.056125
R88 VDD.n27 VDD.n26 0.0341134
R89 VDD.n28 VDD.n27 0.0341134
R90 VDD.n12 VDD 0.014875
R91 OUT OUT.n2 97.5005
R92 OUT OUT.n1 97.5005
R93 OUT OUT.n0 30.8338
R94 OUT.n2 OUT.t0 16.253
R95 OUT.n2 OUT.t1 16.253
R96 OUT.n1 OUT.t2 16.253
R97 OUT.n1 OUT.t3 16.253
R98 OUT.n0 OUT.t4 9.9005
R99 OUT.n0 OUT.t5 9.9005
R100 OUT OUT.n4 7.63902
R101 OUT.n3 OUT 7.13189
R102 OUT.n3 OUT 6.75927
R103 OUT.n4 OUT 5.45674
R104 OUT.n4 OUT.n3 0.83867
R105 IN IN.t2 386.574
R106 IN IN.t1 386.574
R107 IN IN.t0 372.113
R108 IN.n0 IN 25.9221
R109 IN IN.n1 15.0291
R110 IN.n0 IN 14.1917
R111 IN.n1 IN 5.15214
R112 IN.n1 IN.n0 0.830075
R113 GND.n21 GND.n6 18526.3
R114 GND.n22 GND.n21 12422.5
R115 GND.n10 GND.n7 3186.76
R116 GND.n16 GND.n7 3186.76
R117 GND.n10 GND.n8 3186.76
R118 GND.n16 GND.n8 3186.76
R119 GND.n21 GND.n20 2144.89
R120 GND.n19 GND.n3 2126.44
R121 GND.n23 GND.n3 2126.44
R122 GND.n19 GND.n4 2126.44
R123 GND.n23 GND.n4 2126.44
R124 GND.n21 GND.n17 2068.29
R125 GND.t2 GND.n6 1160.98
R126 GND.n17 GND.t2 1160.98
R127 GND.n22 GND.n5 776.269
R128 GND.n20 GND.t0 669.789
R129 GND GND.n23 292.5
R130 GND.n23 GND.n22 292.5
R131 GND.n19 GND.n18 292.5
R132 GND.n20 GND.n19 292.5
R133 GND GND.n9 207.06
R134 GND.n11 GND.n9 207.06
R135 GND GND.n15 168.626
R136 GND.n15 GND.n11 168.626
R137 GND.n4 GND.n1 146.25
R138 GND.n5 GND.n4 146.25
R139 GND.n3 GND.n2 146.25
R140 GND.n5 GND.n3 146.25
R141 GND.n16 GND 146.25
R142 GND.n17 GND.n16 146.25
R143 GND.n11 GND.n10 146.25
R144 GND.n10 GND.n6 146.25
R145 GND.n18 GND.n2 138.166
R146 GND GND.n2 138.166
R147 GND.n18 GND.n1 116.444
R148 GND.n24 GND 115.885
R149 GND.t0 GND.n5 106.48
R150 GND GND.t1 79.0672
R151 GND.n9 GND.n7 73.1255
R152 GND.n7 GND.t2 73.1255
R153 GND.n15 GND.n8 73.1255
R154 GND.n8 GND.t2 73.1255
R155 GND.n12 GND.t4 47.4953
R156 GND GND.t3 40.7338
R157 GND.n25 GND 9.45127
R158 GND.n12 GND 7.13894
R159 GND.n14 GND.n13 5.05128
R160 GND.n26 GND.n25 4.94091
R161 GND.n25 GND.n24 4.22901
R162 GND.n13 GND 1.92914
R163 GND.n15 GND.n14 1.92349
R164 GND GND.n0 1.09809
R165 GND.n0 GND 0.632853
R166 GND.n27 GND 0.495821
R167 GND.n14 GND.n12 0.289528
R168 GND GND.n27 0.225865
R169 GND.n24 GND.n1 0.194439
R170 GND.n13 GND 0.0605
R171 GND.n26 GND.n0 0.0415584
R172 GND GND.n26 0.0202689
R173 GND.n27 GND 0.00202068
C0 OUT IN 0
C1 IN VDD 0.96665f
C2 OUT VDD 1.57211f
C3 OUT GND 1.37709f
C4 IN GND 1.33644f
C5 VDD GND 6.31181f
C6 VDD.t2 GND 0.00985f
C7 VDD.t1 GND 0.00937f
C8 VDD.n0 GND 0.03421f
C9 VDD.n1 GND 0.00908f
C10 VDD.n2 GND 0.01358f
C11 VDD.n3 GND 0.01358f
C12 VDD.t0 GND 0.13262f
C13 VDD.n4 GND 0.01344f
C14 VDD.n6 GND 0.08908f
C15 VDD.n7 GND 0.01358f
C16 VDD.n9 GND 0.08908f
C17 VDD.n10 GND 0.01672f
C18 VDD.n11 GND 0.04674f
C19 VDD.n12 GND 0.01816f
C20 VDD.n13 GND 0.01896f
C21 VDD.n14 GND 0.10342f
C22 VDD.n15 GND 0.01923f
C23 VDD.n16 GND 0.10342f
C24 VDD.t7 GND 0.10186f
C25 VDD.t9 GND 0.05093f
C26 VDD.n17 GND 0.01935f
C27 VDD.t5 GND 0.10186f
C28 VDD.t3 GND 0.05093f
C29 VDD.n18 GND 0.03396f
C30 VDD.n19 GND 0.01935f
C31 VDD.n20 GND 0.0391f
C32 VDD.t6 GND 0.02028f
C33 VDD.t10 GND 0.00557f
C34 VDD.t4 GND 0.00557f
C35 VDD.n21 GND 0.01114f
C36 VDD.n22 GND 0.05138f
C37 VDD.t8 GND 0.01874f
C38 VDD.n23 GND 0.02055f
C39 VDD.n24 GND 0.09757f
C40 VDD.n25 GND 0.35326f
C41 VDD.n26 GND 0.2185f
C42 VDD.n27 GND 0.04387f
C43 VDD.n28 GND 0.17474f
C44 out1.t1 GND 0.02438f
C45 inverter_0.sky130_fd_pr__nfet_01v8_VLDN8W_0.D GND 0.03723f
C46 inverter_0.OUT GND 0.09142f
C47 out1.t7 GND 0.02784f
C48 inverterx4_0.XM2.G3 GND 0.03638f
C49 out1.t3 GND 0.02784f
C50 inverterx4_0.XM2.G1 GND 0.03535f
C51 out1.n0 GND 0.2448f
C52 out1.t5 GND 0.02784f
C53 inverterx4_0.XM2.G0 GND 0.03586f
C54 out1.n1 GND 0.18753f
C55 out1.t8 GND 0.02784f
C56 inverterx4_0.XM2.G2 GND 0.03602f
C57 out1.n2 GND 0.10173f
C58 out1.t4 GND 0.02755f
C59 inverterx4_0.XM1.G1 GND 0.11765f
C60 out1.t6 GND 0.02755f
C61 inverterx4_0.XM1.G0 GND 0.03574f
C62 out1.n3 GND 0.31968f
C63 out1.n4 GND 0.10025f
C64 inverterx4_0.IN GND 0.19157f
C65 out1.n5 GND 0.11385f
C66 out1.n6 GND 0.15744f
C67 out1.t0 GND 0.00831f
C68 out1.t2 GND 0.00831f
C69 out1.n7 GND 0.01662f
C70 inverter_0.XM2.S1 GND 0.03344f
.ends
