** sch_path: /foss/designs/modulo3/lab02/xschem/buffer.sch
.subckt buffer VDD GND OUT IN
*.PININFO IN:I OUT:O VDD:B GND:B
x1 VDD IN out1 GND inverter
x2 VDD out1 OUT GND inverterx4
.ends

* expanding   symbol:  modulo3/lab02/xschem/inverter.sym # of pins=4
** sym_path: /foss/designs/modulo3/lab02/xschem/inverter.sym
** sch_path: /foss/designs/modulo3/lab02/xschem/inverter.sch
.subckt inverter VDD IN OUT GND
*.PININFO IN:I OUT:O VDD:B GND:B
XM1 OUT IN GND GND sky130_fd_pr__nfet_01v8 L=0.15 W=1 nf=1 m=1
XM2 OUT IN VDD VDD sky130_fd_pr__pfet_01v8 L=0.15 W=2 nf=2 m=1
.ends

* expanding   symbol:  modulo3/lab02/xschem/inverterx4.sym # of pins=4
** sym_path: /foss/designs/modulo3/lab02/xschem/inverterx4.sym
** sch_path: /foss/designs/modulo3/lab02/xschem/inverterx4.sch
.subckt inverterx4 VDD IN OUT GND
*.PININFO IN:I OUT:O VDD:B GND:B
XM1 OUT IN GND GND sky130_fd_pr__nfet_01v8 L=0.15 W=4 nf=2 m=1
XM2 OUT IN VDD VDD sky130_fd_pr__pfet_01v8 L=0.15 W=8 nf=4 m=1
.ends
