** sch_path: /foss/designs/modulo3/lab02/xschem/tb_buffer.sch
**.subckt tb_buffer
x1 vdd GND out in buffer
V1 vdd GND 1.8
V2 in GND PULSE(0 1.8 0 100p 100p 4.9n 10n)
C1 out GND 50f m=1
**** begin user architecture code
.lib /foss/pdks/sky130A/libs.tech/combined/sky130.lib.spice tt

.options savecurrents

.control
  save all
  tran 10p 30n

  * trise: ritardo da IN che sale (50%) a OUT che sale (50%)
  meas tran trise TRIG v(IN) VAL=0.9 RISE=1 TARG v(OUT) VAL=0.9 RISE=1

  * tfall: ritardo da IN che scende (50%) a OUT che scende (50%)
  meas tran tfall TRIG v(IN) VAL=0.9 FALL=1 TARG v(OUT) VAL=0.9 FALL=1

  write tb_buffer.raw

.endc

**** end user architecture code
**.ends

* expanding   symbol:  modulo3/lab02/xschem/buffer.sym # of pins=4
** sym_path: /foss/designs/modulo3/lab02/xschem/buffer.sym
** sch_path: /foss/designs/modulo3/lab02/xschem/buffer.sch
.subckt buffer VDD GND OUT IN
*.ipin IN
*.opin OUT
*.iopin VDD
*.iopin GND
x1 VDD IN out1 GND inverter
x2 VDD out1 OUT GND inverterx4
.ends

* expanding   symbol:  modulo3/lab02/xschem/inverter.sym # of pins=4
** sym_path: /foss/designs/modulo3/lab02/xschem/inverter.sym
** sch_path: /foss/designs/modulo3/lab02/xschem/inverter.sch
.subckt inverter VDD IN OUT GND
*.ipin IN
*.opin OUT
*.iopin VDD
*.iopin GND
XM1 OUT IN GND GND sky130_fd_pr__nfet_01v8 L=0.15 W=1 nf=1 ad=0.29 as=0.29 pd=2.58 ps=2.58 nrd=0.29 nrs=0.29 sa=0 sb=0 sd=0 mult=1
+ m=1
XM2 OUT IN VDD VDD sky130_fd_pr__pfet_01v8 L=0.15 W=2 nf=2 ad=0.29 as=0.58 pd=2.58 ps=5.16 nrd=0.145 nrs=0.145 sa=0 sb=0 sd=0
+ mult=1 m=1
.ends

* expanding   symbol:  modulo3/lab02/xschem/inverterx4.sym # of pins=4
** sym_path: /foss/designs/modulo3/lab02/xschem/inverterx4.sym
** sch_path: /foss/designs/modulo3/lab02/xschem/inverterx4.sch
.subckt inverterx4 VDD IN OUT GND
*.ipin IN
*.opin OUT
*.iopin VDD
*.iopin GND
XM1 OUT IN GND GND sky130_fd_pr__nfet_01v8 L=0.15 W=4 nf=2 ad=0.58 as=1.16 pd=4.58 ps=9.16 nrd=0.0725 nrs=0.0725 sa=0 sb=0 sd=0
+ mult=1 m=1
XM2 OUT IN VDD VDD sky130_fd_pr__pfet_01v8 L=0.15 W=8 nf=4 ad=1.16 as=1.74 pd=9.16 ps=13.74 nrd=0.03625 nrs=0.03625 sa=0 sb=0 sd=0
+ mult=1 m=1
.ends

.GLOBAL GND
.end
