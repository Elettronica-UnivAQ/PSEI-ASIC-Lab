* NGSPICE file created from sar_controller.ext - technology: sky130A

* Black-box entry subcircuit for sky130_fd_sc_hd__fill_2 abstract view
.subckt sky130_fd_sc_hd__fill_2 VGND VNB VPB VPWR
.ends

* Black-box entry subcircuit for sky130_fd_sc_hd__decap_3 abstract view
.subckt sky130_fd_sc_hd__decap_3 VGND VNB VPB VPWR
.ends

* Black-box entry subcircuit for sky130_fd_sc_hd__fill_1 abstract view
.subckt sky130_fd_sc_hd__fill_1 VGND VNB VPB VPWR
.ends

* Black-box entry subcircuit for sky130_fd_sc_hd__or2_1 abstract view
.subckt sky130_fd_sc_hd__or2_1 A B VGND VNB VPB VPWR X
.ends

* Black-box entry subcircuit for sky130_fd_sc_hd__and2_1 abstract view
.subckt sky130_fd_sc_hd__and2_1 A B VGND VNB VPB VPWR X
.ends

* Black-box entry subcircuit for sky130_fd_sc_hd__tapvpwrvgnd_1 abstract view
.subckt sky130_fd_sc_hd__tapvpwrvgnd_1 VGND VPWR
.ends

* Black-box entry subcircuit for sky130_fd_sc_hd__clkbuf_1 abstract view
.subckt sky130_fd_sc_hd__clkbuf_1 A VGND VNB VPB VPWR X
.ends

* Black-box entry subcircuit for sky130_fd_sc_hd__o21a_1 abstract view
.subckt sky130_fd_sc_hd__o21a_1 A1 A2 B1 VGND VNB VPB VPWR X
.ends

* Black-box entry subcircuit for sky130_fd_sc_hd__mux2_1 abstract view
.subckt sky130_fd_sc_hd__mux2_1 A0 A1 S VGND VNB VPB VPWR X
.ends

* Black-box entry subcircuit for sky130_fd_sc_hd__dlygate4sd3_1 abstract view
.subckt sky130_fd_sc_hd__dlygate4sd3_1 A VGND VNB VPB VPWR X
.ends

* Black-box entry subcircuit for sky130_fd_sc_hd__nor2_1 abstract view
.subckt sky130_fd_sc_hd__nor2_1 A B VGND VNB VPB VPWR Y
.ends

* Black-box entry subcircuit for sky130_fd_sc_hd__clkbuf_4 abstract view
.subckt sky130_fd_sc_hd__clkbuf_4 A VGND VNB VPB VPWR X
.ends

* Black-box entry subcircuit for sky130_fd_sc_hd__dfrtp_1 abstract view
.subckt sky130_fd_sc_hd__dfrtp_1 CLK D RESET_B VGND VNB VPB VPWR Q
.ends

* Black-box entry subcircuit for sky130_fd_sc_hd__bufinv_16 abstract view
.subckt sky130_fd_sc_hd__bufinv_16 A VGND VNB VPB VPWR Y
.ends

* Black-box entry subcircuit for sky130_fd_sc_hd__dfstp_1 abstract view
.subckt sky130_fd_sc_hd__dfstp_1 CLK D SET_B VGND VNB VPB VPWR Q
.ends

* Black-box entry subcircuit for sky130_fd_sc_hd__clkbuf_16 abstract view
.subckt sky130_fd_sc_hd__clkbuf_16 A VGND VNB VPB VPWR X
.ends

* Black-box entry subcircuit for sky130_fd_sc_hd__and2b_1 abstract view
.subckt sky130_fd_sc_hd__and2b_1 A_N B VGND VNB VPB VPWR X
.ends

* Black-box entry subcircuit for sky130_fd_sc_hd__or3_1 abstract view
.subckt sky130_fd_sc_hd__or3_1 A B C VGND VNB VPB VPWR X
.ends

* Black-box entry subcircuit for sky130_fd_sc_hd__and2_4 abstract view
.subckt sky130_fd_sc_hd__and2_4 A B VGND VNB VPB VPWR X
.ends

* Black-box entry subcircuit for sky130_fd_sc_hd__a21oi_1 abstract view
.subckt sky130_fd_sc_hd__a21oi_1 A1 A2 B1 VGND VNB VPB VPWR Y
.ends

* Black-box entry subcircuit for sky130_fd_sc_hd__or2_4 abstract view
.subckt sky130_fd_sc_hd__or2_4 A B VGND VNB VPB VPWR X
.ends

* Black-box entry subcircuit for sky130_fd_sc_hd__and4bb_4 abstract view
.subckt sky130_fd_sc_hd__and4bb_4 A_N B_N C D VGND VNB VPB VPWR X
.ends

* Black-box entry subcircuit for sky130_fd_sc_hd__or3_4 abstract view
.subckt sky130_fd_sc_hd__or3_4 A B C VGND VNB VPB VPWR X
.ends

* Black-box entry subcircuit for sky130_fd_sc_hd__o31a_1 abstract view
.subckt sky130_fd_sc_hd__o31a_1 A1 A2 A3 B1 VGND VNB VPB VPWR X
.ends

* Black-box entry subcircuit for sky130_fd_sc_hd__nand2b_2 abstract view
.subckt sky130_fd_sc_hd__nand2b_2 A_N B VGND VNB VPB VPWR Y
.ends

* Black-box entry subcircuit for sky130_fd_sc_hd__nor2_2 abstract view
.subckt sky130_fd_sc_hd__nor2_2 A B VGND VNB VPB VPWR Y
.ends

* Black-box entry subcircuit for sky130_fd_sc_hd__and2b_4 abstract view
.subckt sky130_fd_sc_hd__and2b_4 A_N B VGND VNB VPB VPWR X
.ends

* Black-box entry subcircuit for sky130_fd_sc_hd__buf_2 abstract view
.subckt sky130_fd_sc_hd__buf_2 A VGND VNB VPB VPWR X
.ends

* Black-box entry subcircuit for sky130_fd_sc_hd__dfrtp_4 abstract view
.subckt sky130_fd_sc_hd__dfrtp_4 CLK D RESET_B VGND VNB VPB VPWR Q
.ends

* Black-box entry subcircuit for sky130_fd_sc_hd__inv_1 abstract view
.subckt sky130_fd_sc_hd__inv_1 A VGND VNB VPB VPWR Y
.ends

* Black-box entry subcircuit for sky130_fd_sc_hd__clkbuf_2 abstract view
.subckt sky130_fd_sc_hd__clkbuf_2 A VGND VNB VPB VPWR X
.ends

* Black-box entry subcircuit for sky130_fd_sc_hd__a21o_1 abstract view
.subckt sky130_fd_sc_hd__a21o_1 A1 A2 B1 VGND VNB VPB VPWR X
.ends

* Black-box entry subcircuit for sky130_fd_sc_hd__inv_2 abstract view
.subckt sky130_fd_sc_hd__inv_2 A VGND VNB VPB VPWR Y
.ends

* Black-box entry subcircuit for sky130_fd_sc_hd__or4bb_4 abstract view
.subckt sky130_fd_sc_hd__or4bb_4 A B C_N D_N VGND VNB VPB VPWR X
.ends

* Black-box entry subcircuit for sky130_fd_sc_hd__and4b_4 abstract view
.subckt sky130_fd_sc_hd__and4b_4 A_N B C D VGND VNB VPB VPWR X
.ends

* Black-box entry subcircuit for sky130_fd_sc_hd__buf_1 abstract view
.subckt sky130_fd_sc_hd__buf_1 A VGND VNB VPB VPWR X
.ends

* Black-box entry subcircuit for sky130_fd_sc_hd__a211o_1 abstract view
.subckt sky130_fd_sc_hd__a211o_1 A1 A2 B1 C1 VGND VNB VPB VPWR X
.ends

* Black-box entry subcircuit for sky130_fd_sc_hd__o21ba_1 abstract view
.subckt sky130_fd_sc_hd__o21ba_1 A1 A2 B1_N VGND VNB VPB VPWR X
.ends

* Black-box entry subcircuit for sky130_fd_sc_hd__o22a_1 abstract view
.subckt sky130_fd_sc_hd__o22a_1 A1 A2 B1 B2 VGND VNB VPB VPWR X
.ends

* Black-box entry subcircuit for sky130_fd_sc_hd__and4_4 abstract view
.subckt sky130_fd_sc_hd__and4_4 A B C D VGND VNB VPB VPWR X
.ends

* Black-box entry subcircuit for sky130_fd_sc_hd__and3_4 abstract view
.subckt sky130_fd_sc_hd__and3_4 A B C VGND VNB VPB VPWR X
.ends

* Black-box entry subcircuit for sky130_fd_sc_hd__and4bb_1 abstract view
.subckt sky130_fd_sc_hd__and4bb_1 A_N B_N C D VGND VNB VPB VPWR X
.ends

* Black-box entry subcircuit for sky130_fd_sc_hd__o21ai_1 abstract view
.subckt sky130_fd_sc_hd__o21ai_1 A1 A2 B1 VGND VNB VPB VPWR Y
.ends

* Black-box entry subcircuit for sky130_fd_sc_hd__and3_1 abstract view
.subckt sky130_fd_sc_hd__and3_1 A B C VGND VNB VPB VPWR X
.ends

* Black-box entry subcircuit for sky130_fd_sc_hd__a31oi_1 abstract view
.subckt sky130_fd_sc_hd__a31oi_1 A1 A2 A3 B1 VGND VNB VPB VPWR Y
.ends

* Black-box entry subcircuit for sky130_fd_sc_hd__a31o_1 abstract view
.subckt sky130_fd_sc_hd__a31o_1 A1 A2 A3 B1 VGND VNB VPB VPWR X
.ends

* Black-box entry subcircuit for sky130_fd_sc_hd__nand2_1 abstract view
.subckt sky130_fd_sc_hd__nand2_1 A B VGND VNB VPB VPWR Y
.ends

* Black-box entry subcircuit for sky130_fd_sc_hd__or4b_4 abstract view
.subckt sky130_fd_sc_hd__or4b_4 A B C D_N VGND VNB VPB VPWR X
.ends

.subckt sar_controller VGND VPWR clk clk_comp dac_n[0] dac_n[1] dac_n[2] dac_n[3]
+ dac_n[4] dac_n[5] dac_n[6] dac_n[7] dac_p[0] dac_p[1] dac_p[2] dac_p[3] dac_p[4]
+ dac_p[5] dac_p[6] dac_p[7] dout[0] dout[1] dout[2] dout[3] dout[4] dout[5] dout[6]
+ dout[7] eoc out_comp_n out_comp_p phi_sample phi_sample_n rst_n
XFILLER_12_98 VGND VGND VPWR VPWR sky130_fd_sc_hd__fill_2
XFILLER_12_32 VGND VGND VPWR VPWR sky130_fd_sc_hd__decap_3
XFILLER_3_34 VGND VGND VPWR VPWR sky130_fd_sc_hd__fill_1
X_131_ _031_ _038_ VGND VGND VPWR VPWR _014_ sky130_fd_sc_hd__or2_1
XFILLER_9_88 VGND VGND VPWR VPWR sky130_fd_sc_hd__decap_3
XFILLER_9_55 VGND VGND VPWR VPWR sky130_fd_sc_hd__fill_1
XFILLER_9_33 VGND VGND VPWR VPWR sky130_fd_sc_hd__fill_2
XFILLER_0_57 VGND VGND VPWR VPWR sky130_fd_sc_hd__decap_3
X_114_ _062_ _029_ VGND VGND VPWR VPWR _006_ sky130_fd_sc_hd__and2_1
XTAP_TAPCELL_ROW_5_45 VGND VPWR sky130_fd_sc_hd__tapvpwrvgnd_1
Xoutput7 net7 VGND VGND VPWR VPWR dac_n[4] sky130_fd_sc_hd__clkbuf_1
Xoutput20 net21 VGND VGND VPWR VPWR dout[1] sky130_fd_sc_hd__clkbuf_1
XFILLER_3_57 VGND VGND VPWR VPWR sky130_fd_sc_hd__fill_2
X_130_ net46 _054_ net43 VGND VGND VPWR VPWR _038_ sky130_fd_sc_hd__o21a_1
XPHY_EDGE_ROW_12_Right_12 VGND VGND VPWR VPWR sky130_fd_sc_hd__decap_3
XFILLER_12_88 VGND VGND VPWR VPWR sky130_fd_sc_hd__fill_2
XTAP_TAPCELL_ROW_12_55 VGND VPWR sky130_fd_sc_hd__tapvpwrvgnd_1
XFILLER_12_44 VGND VGND VPWR VPWR sky130_fd_sc_hd__fill_1
XFILLER_9_12 VGND VGND VPWR VPWR sky130_fd_sc_hd__decap_3
XPHY_EDGE_ROW_8_Left_26 VGND VGND VPWR VPWR sky130_fd_sc_hd__decap_3
X_113_ net23 net33 _059_ VGND VGND VPWR VPWR _029_ sky130_fd_sc_hd__mux2_1
XFILLER_15_55 VGND VGND VPWR VPWR sky130_fd_sc_hd__fill_1
XPHY_EDGE_ROW_6_Right_6 VGND VGND VPWR VPWR sky130_fd_sc_hd__decap_3
Xoutput10 net10 VGND VGND VPWR VPWR dac_n[7] sky130_fd_sc_hd__clkbuf_1
Xoutput21 net22 VGND VGND VPWR VPWR dout[2] sky130_fd_sc_hd__clkbuf_1
Xoutput8 net8 VGND VGND VPWR VPWR dac_n[5] sky130_fd_sc_hd__clkbuf_1
XTAP_TAPCELL_ROW_12_56 VGND VPWR sky130_fd_sc_hd__tapvpwrvgnd_1
XFILLER_9_106 VGND VGND VPWR VPWR sky130_fd_sc_hd__fill_2
XFILLER_9_24 VGND VGND VPWR VPWR sky130_fd_sc_hd__decap_3
Xhold10 net26 VGND VGND VPWR VPWR net43 sky130_fd_sc_hd__dlygate4sd3_1
XFILLER_6_25 VGND VGND VPWR VPWR sky130_fd_sc_hd__decap_3
X_112_ _060_ _028_ VGND VGND VPWR VPWR _005_ sky130_fd_sc_hd__or2_1
Xoutput22 net23 VGND VGND VPWR VPWR dout[3] sky130_fd_sc_hd__clkbuf_1
Xoutput11 net11 VGND VGND VPWR VPWR dac_p[0] sky130_fd_sc_hd__clkbuf_1
Xoutput9 net9 VGND VGND VPWR VPWR dac_n[6] sky130_fd_sc_hd__clkbuf_1
XFILLER_12_35 VGND VGND VPWR VPWR sky130_fd_sc_hd__decap_3
XFILLER_12_24 VGND VGND VPWR VPWR sky130_fd_sc_hd__decap_3
XFILLER_15_9 VGND VGND VPWR VPWR sky130_fd_sc_hd__decap_3
X_111_ _048_ net8 _026_ VGND VGND VPWR VPWR _028_ sky130_fd_sc_hd__mux2_1
Xoutput23 net24 VGND VGND VPWR VPWR dout[4] sky130_fd_sc_hd__clkbuf_1
Xoutput12 net13 VGND VGND VPWR VPWR dac_p[1] sky130_fd_sc_hd__clkbuf_1
XFILLER_12_14 VGND VGND VPWR VPWR sky130_fd_sc_hd__fill_1
XFILLER_11_3 VGND VGND VPWR VPWR sky130_fd_sc_hd__decap_3
XFILLER_0_39 VGND VGND VPWR VPWR sky130_fd_sc_hd__fill_2
XFILLER_6_16 VGND VGND VPWR VPWR sky130_fd_sc_hd__decap_3
XFILLER_1_60 VGND VGND VPWR VPWR sky130_fd_sc_hd__fill_1
X_110_ _048_ _026_ VGND VGND VPWR VPWR _027_ sky130_fd_sc_hd__nor2_1
Xclkload0 clknet_2_1__leaf_clk_regs VGND VGND VPWR VPWR clkload0/X sky130_fd_sc_hd__clkbuf_4
Xoutput24 net25 VGND VGND VPWR VPWR dout[5] sky130_fd_sc_hd__clkbuf_1
Xoutput13 net14 VGND VGND VPWR VPWR dac_p[2] sky130_fd_sc_hd__clkbuf_1
XTAP_TAPCELL_ROW_8_49 VGND VPWR sky130_fd_sc_hd__tapvpwrvgnd_1
XFILLER_3_28 VGND VGND VPWR VPWR sky130_fd_sc_hd__decap_3
Xclkload1 clknet_2_2__leaf_clk_regs VGND VGND VPWR VPWR clkload1/X sky130_fd_sc_hd__clkbuf_4
XFILLER_9_27 VGND VGND VPWR VPWR sky130_fd_sc_hd__decap_3
XFILLER_4_60 VGND VGND VPWR VPWR sky130_fd_sc_hd__decap_3
XFILLER_1_3 VGND VGND VPWR VPWR sky130_fd_sc_hd__fill_1
XFILLER_3_6 VGND VGND VPWR VPWR sky130_fd_sc_hd__fill_1
X_169_ clknet_2_2__leaf_clk_regs _015_ net51 VGND VGND VPWR VPWR net27 sky130_fd_sc_hd__dfrtp_1
Xoutput25 net26 VGND VGND VPWR VPWR dout[6] sky130_fd_sc_hd__clkbuf_1
XPHY_EDGE_ROW_15_Left_33 VGND VGND VPWR VPWR sky130_fd_sc_hd__decap_3
Xoutput14 net15 VGND VGND VPWR VPWR dac_p[3] sky130_fd_sc_hd__clkbuf_1
XFILLER_12_38 VGND VGND VPWR VPWR sky130_fd_sc_hd__decap_3
XFILLER_12_27 VGND VGND VPWR VPWR sky130_fd_sc_hd__fill_1
XPHY_EDGE_ROW_0_Left_18 VGND VGND VPWR VPWR sky130_fd_sc_hd__decap_3
Xclkload2 clknet_2_3__leaf_clk_regs VGND VGND VPWR VPWR clkload2/Y sky130_fd_sc_hd__bufinv_16
X_168_ clknet_2_2__leaf_clk_regs _014_ net50 VGND VGND VPWR VPWR net26 sky130_fd_sc_hd__dfrtp_1
X_099_ net47 _054_ net22 VGND VGND VPWR VPWR _065_ sky130_fd_sc_hd__o21a_1
XPHY_EDGE_ROW_3_Left_21 VGND VGND VPWR VPWR sky130_fd_sc_hd__decap_3
Xoutput26 net27 VGND VGND VPWR VPWR dout[7] sky130_fd_sc_hd__clkbuf_1
XFILLER_11_6 VGND VGND VPWR VPWR sky130_fd_sc_hd__decap_3
XFILLER_6_29 VGND VGND VPWR VPWR sky130_fd_sc_hd__decap_3
Xoutput15 net16 VGND VGND VPWR VPWR dac_p[4] sky130_fd_sc_hd__clkbuf_1
XPHY_EDGE_ROW_1_Right_1 VGND VGND VPWR VPWR sky130_fd_sc_hd__decap_3
XFILLER_13_60 VGND VGND VPWR VPWR sky130_fd_sc_hd__fill_2
XFILLER_2_106 VGND VGND VPWR VPWR sky130_fd_sc_hd__fill_2
XFILLER_10_83 VGND VGND VPWR VPWR sky130_fd_sc_hd__fill_1
XFILLER_10_50 VGND VGND VPWR VPWR sky130_fd_sc_hd__fill_1
XFILLER_6_19 VGND VGND VPWR VPWR sky130_fd_sc_hd__decap_3
X_098_ _063_ _064_ _062_ VGND VGND VPWR VPWR _001_ sky130_fd_sc_hd__o21a_1
X_167_ clknet_2_1__leaf_clk_regs _013_ net32 VGND VGND VPWR VPWR net6 sky130_fd_sc_hd__dfstp_1
Xclkbuf_0_clk clk VGND VGND VPWR VPWR clknet_0_clk sky130_fd_sc_hd__clkbuf_16
XPHY_EDGE_ROW_15_Right_15 VGND VGND VPWR VPWR sky130_fd_sc_hd__decap_3
Xoutput27 net28 VGND VGND VPWR VPWR eoc sky130_fd_sc_hd__clkbuf_1
Xoutput16 net17 VGND VGND VPWR VPWR dac_p[5] sky130_fd_sc_hd__clkbuf_1
XFILLER_12_29 VGND VGND VPWR VPWR sky130_fd_sc_hd__decap_3
XFILLER_4_85 VGND VGND VPWR VPWR sky130_fd_sc_hd__fill_2
XFILLER_4_74 VGND VGND VPWR VPWR sky130_fd_sc_hd__fill_2
XFILLER_4_63 VGND VGND VPWR VPWR sky130_fd_sc_hd__decap_3
X_166_ clknet_2_2__leaf_clk_regs _012_ net31 VGND VGND VPWR VPWR net25 sky130_fd_sc_hd__dfrtp_1
XTAP_TAPCELL_ROW_9_51 VGND VPWR sky130_fd_sc_hd__tapvpwrvgnd_1
X_097_ _000_ net20 VGND VGND VPWR VPWR _064_ sky130_fd_sc_hd__and2b_1
Xoutput28 net29 VGND VGND VPWR VPWR phi_sample sky130_fd_sc_hd__clkbuf_1
Xclkbuf_regs_0_clk clk VGND VGND VPWR VPWR clk_regs sky130_fd_sc_hd__clkbuf_16
X_149_ net45 _063_ _045_ VGND VGND VPWR VPWR _025_ sky130_fd_sc_hd__or3_1
Xoutput17 net18 VGND VGND VPWR VPWR dac_p[6] sky130_fd_sc_hd__clkbuf_1
XTAP_TAPCELL_ROW_16_61 VGND VPWR sky130_fd_sc_hd__tapvpwrvgnd_1
XTAP_TAPCELL_ROW_3_42 VGND VPWR sky130_fd_sc_hd__tapvpwrvgnd_1
XFILLER_4_53 VGND VGND VPWR VPWR sky130_fd_sc_hd__decap_3
XFILLER_4_42 VGND VGND VPWR VPWR sky130_fd_sc_hd__fill_1
XFILLER_10_85 VGND VGND VPWR VPWR sky130_fd_sc_hd__fill_2
XTAP_TAPCELL_ROW_10_52 VGND VPWR sky130_fd_sc_hd__tapvpwrvgnd_1
XPHY_EDGE_ROW_7_Left_25 VGND VGND VPWR VPWR sky130_fd_sc_hd__decap_3
X_096_ net33 _000_ VGND VGND VPWR VPWR _063_ sky130_fd_sc_hd__and2_4
X_148_ _000_ net11 VGND VGND VPWR VPWR _045_ sky130_fd_sc_hd__and2b_1
XFILLER_1_7 VGND VGND VPWR VPWR sky130_fd_sc_hd__fill_2
X_165_ clknet_2_1__leaf_clk_regs _011_ net32 VGND VGND VPWR VPWR net7 sky130_fd_sc_hd__dfstp_1
X_079_ state\[2\] net46 net37 VGND VGND VPWR VPWR :61.Y\[0\] sky130_fd_sc_hd__a21oi_1
XTAP_TAPCELL_ROW_16_62 VGND VPWR sky130_fd_sc_hd__tapvpwrvgnd_1
Xoutput29 net30 VGND VGND VPWR VPWR phi_sample_n sky130_fd_sc_hd__clkbuf_1
XPHY_EDGE_ROW_5_Right_5 VGND VGND VPWR VPWR sky130_fd_sc_hd__decap_3
Xoutput18 net19 VGND VGND VPWR VPWR dac_p[7] sky130_fd_sc_hd__clkbuf_1
XFILLER_16_73 VGND VGND VPWR VPWR sky130_fd_sc_hd__decap_3
XFILLER_4_21 VGND VGND VPWR VPWR sky130_fd_sc_hd__decap_3
X_164_ clknet_2_2__leaf_clk_regs _000_ net31 VGND VGND VPWR VPWR net28 sky130_fd_sc_hd__dfrtp_1
X_095_ net49 _061_ VGND VGND VPWR VPWR _062_ sky130_fd_sc_hd__or2_4
X_078_ state\[0\] state\[2\] net46 state\[1\] VGND VGND VPWR VPWR _000_ sky130_fd_sc_hd__and4bb_4
XTAP_TAPCELL_ROW_10_53 VGND VPWR sky130_fd_sc_hd__tapvpwrvgnd_1
X_147_ net45 _067_ _044_ VGND VGND VPWR VPWR _024_ sky130_fd_sc_hd__or3_1
Xoutput19 net20 VGND VGND VPWR VPWR dout[0] sky130_fd_sc_hd__clkbuf_1
XPHY_EDGE_ROW_11_Right_11 VGND VGND VPWR VPWR sky130_fd_sc_hd__decap_3
XFILLER_5_107 VGND VGND VPWR VPWR sky130_fd_sc_hd__fill_1
XFILLER_4_66 VGND VGND VPWR VPWR sky130_fd_sc_hd__decap_3
X_163_ clknet_2_3__leaf_clk_regs _010_ net52 VGND VGND VPWR VPWR net10 sky130_fd_sc_hd__dfstp_1
X_094_ net48 net47 state\[3\] VGND VGND VPWR VPWR _061_ sky130_fd_sc_hd__or3_4
X_146_ _046_ state\[1\] _050_ net13 VGND VGND VPWR VPWR _044_ sky130_fd_sc_hd__o31a_1
X_077_ net47 state\[3\] VGND VGND VPWR VPWR _050_ sky130_fd_sc_hd__nand2b_2
XFILLER_7_99 VGND VGND VPWR VPWR sky130_fd_sc_hd__decap_3
X_129_ _060_ _037_ VGND VGND VPWR VPWR _013_ sky130_fd_sc_hd__or2_1
XFILLER_4_56 VGND VGND VPWR VPWR sky130_fd_sc_hd__fill_1
X_162_ clknet_2_2__leaf_clk_regs _009_ net50 VGND VGND VPWR VPWR net19 sky130_fd_sc_hd__dfstp_1
XFILLER_13_32 VGND VGND VPWR VPWR sky130_fd_sc_hd__fill_2
X_093_ net48 _055_ VGND VGND VPWR VPWR _060_ sky130_fd_sc_hd__nor2_2
Xinput1 out_comp_p VGND VGND VPWR VPWR net1 sky130_fd_sc_hd__clkbuf_1
X_076_ net47 state\[3\] VGND VGND VPWR VPWR _049_ sky130_fd_sc_hd__and2b_4
X_145_ net45 _066_ _043_ VGND VGND VPWR VPWR _023_ sky130_fd_sc_hd__or3_1
Xmax_cap30 net51 VGND VGND VPWR VPWR net31 sky130_fd_sc_hd__buf_2
XFILLER_16_32 VGND VGND VPWR VPWR sky130_fd_sc_hd__decap_3
XPHY_EDGE_ROW_9_Right_9 VGND VGND VPWR VPWR sky130_fd_sc_hd__decap_3
XFILLER_7_23 VGND VGND VPWR VPWR sky130_fd_sc_hd__fill_2
X_128_ net6 _048_ _059_ VGND VGND VPWR VPWR _037_ sky130_fd_sc_hd__mux2_1
Xfanout12 rst_n VGND VGND VPWR VPWR net12 sky130_fd_sc_hd__clkbuf_1
XFILLER_13_55 VGND VGND VPWR VPWR sky130_fd_sc_hd__fill_1
XTAP_TAPCELL_ROW_0_36 VGND VPWR sky130_fd_sc_hd__tapvpwrvgnd_1
XFILLER_4_24 VGND VGND VPWR VPWR sky130_fd_sc_hd__decap_3
X_092_ net29 clknet_1_0__leaf_clk VGND VGND VPWR VPWR net2 sky130_fd_sc_hd__nor2_2
X_161_ clknet_2_3__leaf_clk_regs _008_ net52 VGND VGND VPWR VPWR net29 sky130_fd_sc_hd__dfrtp_4
XFILLER_10_23 VGND VGND VPWR VPWR sky130_fd_sc_hd__decap_3
X_075_ net29 VGND VGND VPWR VPWR net30 sky130_fd_sc_hd__inv_1
Xmax_cap31 net12 VGND VGND VPWR VPWR net32 sky130_fd_sc_hd__clkbuf_2
X_127_ _062_ _036_ VGND VGND VPWR VPWR _012_ sky130_fd_sc_hd__and2_1
XPHY_EDGE_ROW_11_Left_29 VGND VGND VPWR VPWR sky130_fd_sc_hd__decap_3
X_144_ _050_ _054_ net14 VGND VGND VPWR VPWR _043_ sky130_fd_sc_hd__o21a_1
XFILLER_7_57 VGND VGND VPWR VPWR sky130_fd_sc_hd__fill_1
XTAP_TAPCELL_ROW_6_46 VGND VPWR sky130_fd_sc_hd__tapvpwrvgnd_1
XFILLER_7_46 VGND VGND VPWR VPWR sky130_fd_sc_hd__decap_3
XPHY_EDGE_ROW_14_Left_32 VGND VGND VPWR VPWR sky130_fd_sc_hd__decap_3
XFILLER_4_36 VGND VGND VPWR VPWR sky130_fd_sc_hd__decap_3
XFILLER_13_23 VGND VGND VPWR VPWR sky130_fd_sc_hd__decap_3
XFILLER_4_69 VGND VGND VPWR VPWR sky130_fd_sc_hd__fill_1
XTAP_TAPCELL_ROW_0_37 VGND VPWR sky130_fd_sc_hd__tapvpwrvgnd_1
X_091_ _047_ _049_ _059_ VGND VGND VPWR VPWR :61.Y\[3\] sky130_fd_sc_hd__a21o_1
X_160_ clknet_2_1__leaf_clk_regs :61.Y\[3\] net52 VGND VGND VPWR VPWR state\[3\] sky130_fd_sc_hd__dfrtp_4
XTAP_TAPCELL_ROW_6_47 VGND VPWR sky130_fd_sc_hd__tapvpwrvgnd_1
X_143_ net45 _042_ VGND VGND VPWR VPWR _022_ sky130_fd_sc_hd__or2_1
X_074_ net33 VGND VGND VPWR VPWR _048_ sky130_fd_sc_hd__inv_2
XPHY_EDGE_ROW_2_Left_20 VGND VGND VPWR VPWR sky130_fd_sc_hd__decap_3
XFILLER_16_45 VGND VGND VPWR VPWR sky130_fd_sc_hd__fill_2
X_126_ net33 net25 _026_ VGND VGND VPWR VPWR _036_ sky130_fd_sc_hd__mux2_1
XPHY_EDGE_ROW_0_Right_0 VGND VGND VPWR VPWR sky130_fd_sc_hd__decap_3
Xmax_cap32 net1 VGND VGND VPWR VPWR net33 sky130_fd_sc_hd__clkbuf_2
XTAP_TAPCELL_ROW_13_57 VGND VPWR sky130_fd_sc_hd__tapvpwrvgnd_1
XFILLER_13_57 VGND VGND VPWR VPWR sky130_fd_sc_hd__decap_3
X_109_ net48 net46 net47 net49 VGND VGND VPWR VPWR _026_ sky130_fd_sc_hd__or4bb_4
XTAP_TAPCELL_ROW_0_38 VGND VPWR sky130_fd_sc_hd__tapvpwrvgnd_1
X_090_ state\[3\] net47 net48 net49 VGND VGND VPWR VPWR _059_ sky130_fd_sc_hd__and4b_4
Xplace50 net12 VGND VGND VPWR VPWR net50 sky130_fd_sc_hd__buf_1
Xclkbuf_2_3__f_clk_regs clknet_0_clk_regs VGND VGND VPWR VPWR clknet_2_3__leaf_clk_regs
+ sky130_fd_sc_hd__clkbuf_16
X_073_ net48 VGND VGND VPWR VPWR _047_ sky130_fd_sc_hd__inv_1
X_142_ net15 net33 _059_ VGND VGND VPWR VPWR _042_ sky130_fd_sc_hd__mux2_1
X_125_ _060_ _035_ VGND VGND VPWR VPWR _011_ sky130_fd_sc_hd__or2_1
XFILLER_16_35 VGND VGND VPWR VPWR sky130_fd_sc_hd__decap_3
X_108_ _062_ _071_ VGND VGND VPWR VPWR _004_ sky130_fd_sc_hd__and2_1
XFILLER_4_27 VGND VGND VPWR VPWR sky130_fd_sc_hd__fill_1
Xclkbuf_2_2__f_clk_regs clknet_0_clk_regs VGND VGND VPWR VPWR clknet_2_2__leaf_clk_regs
+ sky130_fd_sc_hd__clkbuf_16
Xplace51 net50 VGND VGND VPWR VPWR net51 sky130_fd_sc_hd__clkbuf_1
X_072_ state\[0\] VGND VGND VPWR VPWR _046_ sky130_fd_sc_hd__inv_1
XFILLER_10_26 VGND VGND VPWR VPWR sky130_fd_sc_hd__fill_2
X_141_ net16 _069_ _070_ net45 VGND VGND VPWR VPWR _021_ sky130_fd_sc_hd__a211o_1
XFILLER_16_6 VGND VGND VPWR VPWR sky130_fd_sc_hd__fill_2
X_124_ _048_ net7 _069_ VGND VGND VPWR VPWR _035_ sky130_fd_sc_hd__mux2_1
XFILLER_14_3 VGND VGND VPWR VPWR sky130_fd_sc_hd__decap_3
X_107_ net33 net24 _069_ VGND VGND VPWR VPWR _071_ sky130_fd_sc_hd__mux2_1
Xclkbuf_2_1__f_clk_regs clknet_0_clk_regs VGND VGND VPWR VPWR clknet_2_1__leaf_clk_regs
+ sky130_fd_sc_hd__clkbuf_16
XFILLER_4_39 VGND VGND VPWR VPWR sky130_fd_sc_hd__decap_3
XFILLER_13_26 VGND VGND VPWR VPWR sky130_fd_sc_hd__decap_3
XFILLER_5_60 VGND VGND VPWR VPWR sky130_fd_sc_hd__decap_3
XPHY_EDGE_ROW_14_Right_14 VGND VGND VPWR VPWR sky130_fd_sc_hd__decap_3
XPHY_EDGE_ROW_6_Left_24 VGND VGND VPWR VPWR sky130_fd_sc_hd__decap_3
X_140_ net17 _026_ _027_ net45 VGND VGND VPWR VPWR _020_ sky130_fd_sc_hd__a211o_1
Xplace52 net32 VGND VGND VPWR VPWR net52 sky130_fd_sc_hd__buf_1
X_123_ net42 _033_ _034_ VGND VGND VPWR VPWR _010_ sky130_fd_sc_hd__o21ba_1
XFILLER_8_82 VGND VGND VPWR VPWR sky130_fd_sc_hd__fill_2
Xclkbuf_2_0__f_clk_regs clknet_0_clk_regs VGND VGND VPWR VPWR clknet_2_0__leaf_clk_regs
+ sky130_fd_sc_hd__clkbuf_16
XPHY_EDGE_ROW_4_Right_4 VGND VGND VPWR VPWR sky130_fd_sc_hd__decap_3
X_106_ _048_ _069_ VGND VGND VPWR VPWR _070_ sky130_fd_sc_hd__nor2_1
XFILLER_1_106 VGND VGND VPWR VPWR sky130_fd_sc_hd__fill_2
XFILLER_6_6 VGND VGND VPWR VPWR sky130_fd_sc_hd__decap_3
XFILLER_4_3 VGND VGND VPWR VPWR sky130_fd_sc_hd__fill_1
XFILLER_16_38 VGND VGND VPWR VPWR sky130_fd_sc_hd__fill_2
X_122_ net1 _056_ VGND VGND VPWR VPWR _034_ sky130_fd_sc_hd__and2_4
X_105_ net49 net46 net47 net48 VGND VGND VPWR VPWR _069_ sky130_fd_sc_hd__or4bb_4
Xclkbuf_1_0__f_clk clknet_0_clk VGND VGND VPWR VPWR clknet_1_0__leaf_clk sky130_fd_sc_hd__clkbuf_16
XFILLER_14_6 VGND VGND VPWR VPWR sky130_fd_sc_hd__decap_3
X_121_ net1 _057_ _033_ net39 VGND VGND VPWR VPWR _009_ sky130_fd_sc_hd__o22a_1
X_104_ _067_ _068_ _062_ VGND VGND VPWR VPWR _003_ sky130_fd_sc_hd__o21a_1
XFILLER_7_102 VGND VGND VPWR VPWR sky130_fd_sc_hd__decap_3
XFILLER_11_84 VGND VGND VPWR VPWR sky130_fd_sc_hd__fill_1
X_120_ _046_ state\[1\] _055_ VGND VGND VPWR VPWR _033_ sky130_fd_sc_hd__a21oi_1
XPHY_EDGE_ROW_10_Right_10 VGND VGND VPWR VPWR sky130_fd_sc_hd__decap_3
XFILLER_2_75 VGND VGND VPWR VPWR sky130_fd_sc_hd__decap_3
XFILLER_17_72 VGND VGND VPWR VPWR sky130_fd_sc_hd__fill_1
XFILLER_17_50 VGND VGND VPWR VPWR sky130_fd_sc_hd__decap_3
XFILLER_16_29 VGND VGND VPWR VPWR sky130_fd_sc_hd__decap_3
X_103_ _046_ state\[1\] _050_ net21 VGND VGND VPWR VPWR _068_ sky130_fd_sc_hd__o31a_1
Xhold1 net27 VGND VGND VPWR VPWR net34 sky130_fd_sc_hd__dlygate4sd3_1
XPHY_EDGE_ROW_8_Right_8 VGND VGND VPWR VPWR sky130_fd_sc_hd__decap_3
XFILLER_6_9 VGND VGND VPWR VPWR sky130_fd_sc_hd__fill_1
XFILLER_2_32 VGND VGND VPWR VPWR sky130_fd_sc_hd__decap_3
Xplace45 _060_ VGND VGND VPWR VPWR net45 sky130_fd_sc_hd__buf_1
XPHY_EDGE_ROW_10_Left_28 VGND VGND VPWR VPWR sky130_fd_sc_hd__decap_3
X_102_ net49 _047_ net1 _049_ VGND VGND VPWR VPWR _067_ sky130_fd_sc_hd__and4_4
X_179_ clknet_2_0__leaf_clk_regs _025_ net31 VGND VGND VPWR VPWR net11 sky130_fd_sc_hd__dfstp_1
XPHY_EDGE_ROW_13_Left_31 VGND VGND VPWR VPWR sky130_fd_sc_hd__decap_3
Xhold2 net4 VGND VGND VPWR VPWR net35 sky130_fd_sc_hd__dlygate4sd3_1
XTAP_TAPCELL_ROW_4_43 VGND VPWR sky130_fd_sc_hd__tapvpwrvgnd_1
XFILLER_11_20 VGND VGND VPWR VPWR sky130_fd_sc_hd__decap_3
Xplace46 state\[3\] VGND VGND VPWR VPWR net46 sky130_fd_sc_hd__buf_1
XTAP_TAPCELL_ROW_17_63 VGND VPWR sky130_fd_sc_hd__tapvpwrvgnd_1
XFILLER_14_9 VGND VGND VPWR VPWR sky130_fd_sc_hd__decap_3
X_178_ clknet_2_2__leaf_clk_regs _024_ net50 VGND VGND VPWR VPWR net13 sky130_fd_sc_hd__dfstp_1
X_101_ _065_ _066_ VGND VGND VPWR VPWR _002_ sky130_fd_sc_hd__or2_1
XFILLER_8_32 VGND VGND VPWR VPWR sky130_fd_sc_hd__fill_2
XFILLER_17_41 VGND VGND VPWR VPWR sky130_fd_sc_hd__decap_3
XFILLER_12_6 VGND VGND VPWR VPWR sky130_fd_sc_hd__decap_3
XFILLER_5_55 VGND VGND VPWR VPWR sky130_fd_sc_hd__fill_1
Xhold3 net5 VGND VGND VPWR VPWR net36 sky130_fd_sc_hd__dlygate4sd3_1
XTAP_TAPCELL_ROW_4_44 VGND VPWR sky130_fd_sc_hd__tapvpwrvgnd_1
Xplace47 state\[2\] VGND VGND VPWR VPWR net47 sky130_fd_sc_hd__buf_1
Xclkbuf_0_clk_regs clk_regs VGND VGND VPWR VPWR clknet_0_clk_regs sky130_fd_sc_hd__clkbuf_16
XFILLER_2_78 VGND VGND VPWR VPWR sky130_fd_sc_hd__fill_1
XTAP_TAPCELL_ROW_11_54 VGND VPWR sky130_fd_sc_hd__tapvpwrvgnd_1
X_100_ net1 _049_ _053_ VGND VGND VPWR VPWR _066_ sky130_fd_sc_hd__and3_4
X_177_ clknet_2_0__leaf_clk_regs _023_ net50 VGND VGND VPWR VPWR net14 sky130_fd_sc_hd__dfstp_1
XTAP_TAPCELL_ROW_17_64 VGND VPWR sky130_fd_sc_hd__tapvpwrvgnd_1
XFILLER_17_53 VGND VGND VPWR VPWR sky130_fd_sc_hd__decap_3
Xhold4 state\[0\] VGND VGND VPWR VPWR net37 sky130_fd_sc_hd__dlygate4sd3_1
XPHY_EDGE_ROW_17_Right_17 VGND VGND VPWR VPWR sky130_fd_sc_hd__decap_3
Xplace48 state\[1\] VGND VGND VPWR VPWR net48 sky130_fd_sc_hd__buf_1
XFILLER_2_35 VGND VGND VPWR VPWR sky130_fd_sc_hd__decap_3
XTAP_TAPCELL_ROW_17_65 VGND VPWR sky130_fd_sc_hd__tapvpwrvgnd_1
X_159_ clknet_2_3__leaf_clk_regs :61.Y\[2\] net12 VGND VGND VPWR VPWR state\[2\] sky130_fd_sc_hd__dfrtp_4
XFILLER_8_23 VGND VGND VPWR VPWR sky130_fd_sc_hd__decap_3
XFILLER_0_3 VGND VGND VPWR VPWR sky130_fd_sc_hd__fill_1
X_176_ clknet_2_0__leaf_clk_regs _022_ net31 VGND VGND VPWR VPWR net15 sky130_fd_sc_hd__dfstp_1
XFILLER_17_32 VGND VGND VPWR VPWR sky130_fd_sc_hd__decap_3
Xhold5 :61.Y\[0\] VGND VGND VPWR VPWR net38 sky130_fd_sc_hd__dlygate4sd3_1
XFILLER_5_57 VGND VGND VPWR VPWR sky130_fd_sc_hd__decap_3
XPHY_EDGE_ROW_17_Left_35 VGND VGND VPWR VPWR sky130_fd_sc_hd__decap_3
Xplace49 state\[0\] VGND VGND VPWR VPWR net49 sky130_fd_sc_hd__buf_1
XFILLER_11_23 VGND VGND VPWR VPWR sky130_fd_sc_hd__decap_3
X_175_ clknet_2_0__leaf_clk_regs _021_ net31 VGND VGND VPWR VPWR net16 sky130_fd_sc_hd__dfstp_1
X_089_ _051_ _058_ _056_ VGND VGND VPWR VPWR :61.Y\[2\] sky130_fd_sc_hd__a21o_1
XFILLER_17_44 VGND VGND VPWR VPWR sky130_fd_sc_hd__decap_3
X_158_ clknet_2_3__leaf_clk_regs :61.Y\[1\] net12 VGND VGND VPWR VPWR state\[1\] sky130_fd_sc_hd__dfrtp_4
Xhold6 net19 VGND VGND VPWR VPWR net39 sky130_fd_sc_hd__dlygate4sd3_1
XPHY_EDGE_ROW_5_Left_23 VGND VGND VPWR VPWR sky130_fd_sc_hd__decap_3
XFILLER_14_12 VGND VGND VPWR VPWR sky130_fd_sc_hd__decap_3
XPHY_EDGE_ROW_3_Right_3 VGND VGND VPWR VPWR sky130_fd_sc_hd__decap_3
XFILLER_2_15 VGND VGND VPWR VPWR sky130_fd_sc_hd__fill_1
X_088_ net46 state\[2\] VGND VGND VPWR VPWR _058_ sky130_fd_sc_hd__and2b_1
X_157_ clknet_2_3__leaf_clk_regs net38 net32 VGND VGND VPWR VPWR state\[0\] sky130_fd_sc_hd__dfrtp_4
X_174_ clknet_2_0__leaf_clk_regs _020_ net52 VGND VGND VPWR VPWR net17 sky130_fd_sc_hd__dfstp_1
Xhold7 net3 VGND VGND VPWR VPWR net40 sky130_fd_sc_hd__dlygate4sd3_1
XPHY_EDGE_ROW_13_Right_13 VGND VGND VPWR VPWR sky130_fd_sc_hd__decap_3
XFILLER_5_48 VGND VGND VPWR VPWR sky130_fd_sc_hd__decap_3
XFILLER_11_14 VGND VGND VPWR VPWR sky130_fd_sc_hd__decap_3
XTAP_TAPCELL_ROW_7_48 VGND VPWR sky130_fd_sc_hd__tapvpwrvgnd_1
XFILLER_2_38 VGND VGND VPWR VPWR sky130_fd_sc_hd__fill_1
X_173_ clknet_2_0__leaf_clk_regs _019_ net52 VGND VGND VPWR VPWR net18 sky130_fd_sc_hd__dfstp_1
XFILLER_17_79 VGND VGND VPWR VPWR sky130_fd_sc_hd__fill_1
XFILLER_17_57 VGND VGND VPWR VPWR sky130_fd_sc_hd__fill_2
XFILLER_17_35 VGND VGND VPWR VPWR sky130_fd_sc_hd__decap_3
Xhold8 net29 VGND VGND VPWR VPWR net41 sky130_fd_sc_hd__dlygate4sd3_1
X_087_ _051_ _055_ VGND VGND VPWR VPWR _057_ sky130_fd_sc_hd__or2_4
XFILLER_8_26 VGND VGND VPWR VPWR sky130_fd_sc_hd__fill_2
X_156_ clknet_2_1__leaf_clk_regs _007_ net32 VGND VGND VPWR VPWR net9 sky130_fd_sc_hd__dfstp_1
XFILLER_3_70 VGND VGND VPWR VPWR sky130_fd_sc_hd__decap_3
XTAP_TAPCELL_ROW_14_58 VGND VPWR sky130_fd_sc_hd__tapvpwrvgnd_1
XFILLER_9_91 VGND VGND VPWR VPWR sky130_fd_sc_hd__fill_2
X_139_ net18 _030_ _031_ net45 VGND VGND VPWR VPWR _019_ sky130_fd_sc_hd__a211o_1
XTAP_TAPCELL_ROW_1_39 VGND VPWR sky130_fd_sc_hd__tapvpwrvgnd_1
X_086_ state\[2\] net46 state\[0\] state\[1\] VGND VGND VPWR VPWR _056_ sky130_fd_sc_hd__and4bb_1
X_155_ clknet_2_0__leaf_clk_regs _006_ net31 VGND VGND VPWR VPWR net23 sky130_fd_sc_hd__dfrtp_1
X_172_ clknet_2_0__leaf_clk_regs _018_ net52 VGND VGND VPWR VPWR net3 sky130_fd_sc_hd__dfstp_1
XFILLER_17_69 VGND VGND VPWR VPWR sky130_fd_sc_hd__decap_3
XFILLER_17_47 VGND VGND VPWR VPWR sky130_fd_sc_hd__decap_3
Xhold9 net10 VGND VGND VPWR VPWR net42 sky130_fd_sc_hd__dlygate4sd3_1
XPHY_EDGE_ROW_9_Left_27 VGND VGND VPWR VPWR sky130_fd_sc_hd__decap_3
X_138_ _063_ _041_ _061_ VGND VGND VPWR VPWR _018_ sky130_fd_sc_hd__o21ai_1
XFILLER_3_103 VGND VGND VPWR VPWR sky130_fd_sc_hd__fill_2
XTAP_TAPCELL_ROW_14_59 VGND VPWR sky130_fd_sc_hd__tapvpwrvgnd_1
XPHY_EDGE_ROW_7_Right_7 VGND VGND VPWR VPWR sky130_fd_sc_hd__decap_3
X_171_ clknet_2_1__leaf_clk_regs _017_ net52 VGND VGND VPWR VPWR net4 sky130_fd_sc_hd__dfstp_1
XFILLER_2_29 VGND VGND VPWR VPWR sky130_fd_sc_hd__decap_3
X_085_ state\[2\] net46 VGND VGND VPWR VPWR _055_ sky130_fd_sc_hd__or2_4
XFILLER_6_101 VGND VGND VPWR VPWR sky130_fd_sc_hd__decap_3
X_154_ clknet_2_1__leaf_clk_regs _005_ net32 VGND VGND VPWR VPWR net8 sky130_fd_sc_hd__dfstp_1
X_137_ net40 _000_ VGND VGND VPWR VPWR _041_ sky130_fd_sc_hd__nor2_1
XFILLER_0_51 VGND VGND VPWR VPWR sky130_fd_sc_hd__fill_1
XFILLER_0_107 VGND VGND VPWR VPWR sky130_fd_sc_hd__fill_1
XFILLER_14_49 VGND VGND VPWR VPWR sky130_fd_sc_hd__fill_2
XPHY_EDGE_ROW_12_Left_30 VGND VGND VPWR VPWR sky130_fd_sc_hd__decap_3
XTAP_TAPCELL_ROW_2_40 VGND VPWR sky130_fd_sc_hd__tapvpwrvgnd_1
XFILLER_11_17 VGND VGND VPWR VPWR sky130_fd_sc_hd__decap_3
X_170_ clknet_2_1__leaf_clk_regs _016_ net52 VGND VGND VPWR VPWR net5 sky130_fd_sc_hd__dfstp_1
XFILLER_3_73 VGND VGND VPWR VPWR sky130_fd_sc_hd__decap_3
XFILLER_3_84 VGND VGND VPWR VPWR sky130_fd_sc_hd__fill_1
XFILLER_17_38 VGND VGND VPWR VPWR sky130_fd_sc_hd__decap_3
XFILLER_17_27 VGND VGND VPWR VPWR sky130_fd_sc_hd__fill_1
X_084_ _051_ _052_ _054_ VGND VGND VPWR VPWR :61.Y\[1\] sky130_fd_sc_hd__and3_1
X_153_ clknet_2_2__leaf_clk_regs _004_ net31 VGND VGND VPWR VPWR net24 sky130_fd_sc_hd__dfrtp_1
X_136_ _067_ _040_ _061_ VGND VGND VPWR VPWR _017_ sky130_fd_sc_hd__o21ai_1
XTAP_TAPCELL_ROW_8_50 VGND VPWR sky130_fd_sc_hd__tapvpwrvgnd_1
XFILLER_8_29 VGND VGND VPWR VPWR sky130_fd_sc_hd__decap_3
XFILLER_0_63 VGND VGND VPWR VPWR sky130_fd_sc_hd__decap_3
XFILLER_0_85 VGND VGND VPWR VPWR sky130_fd_sc_hd__fill_1
X_119_ state\[0\] _055_ _060_ net41 VGND VGND VPWR VPWR _008_ sky130_fd_sc_hd__o22a_1
Xoutput2 net2 VGND VGND VPWR VPWR clk_comp sky130_fd_sc_hd__buf_1
XTAP_TAPCELL_ROW_15_60 VGND VPWR sky130_fd_sc_hd__tapvpwrvgnd_1
XFILLER_9_6 VGND VGND VPWR VPWR sky130_fd_sc_hd__decap_3
XFILLER_7_3 VGND VGND VPWR VPWR sky130_fd_sc_hd__decap_3
XTAP_TAPCELL_ROW_2_41 VGND VPWR sky130_fd_sc_hd__tapvpwrvgnd_1
X_083_ state\[0\] state\[1\] VGND VGND VPWR VPWR _054_ sky130_fd_sc_hd__or2_4
X_152_ clknet_2_2__leaf_clk_regs _003_ net50 VGND VGND VPWR VPWR net21 sky130_fd_sc_hd__dfrtp_1
X_135_ net49 _047_ _049_ net35 VGND VGND VPWR VPWR _040_ sky130_fd_sc_hd__a31oi_1
X_118_ _060_ _032_ VGND VGND VPWR VPWR _007_ sky130_fd_sc_hd__or2_1
Xoutput3 net3 VGND VGND VPWR VPWR dac_n[0] sky130_fd_sc_hd__clkbuf_1
XFILLER_3_31 VGND VGND VPWR VPWR sky130_fd_sc_hd__decap_3
XFILLER_17_29 VGND VGND VPWR VPWR sky130_fd_sc_hd__decap_3
XFILLER_9_30 VGND VGND VPWR VPWR sky130_fd_sc_hd__decap_3
XFILLER_6_104 VGND VGND VPWR VPWR sky130_fd_sc_hd__fill_1
X_134_ _066_ _039_ _061_ VGND VGND VPWR VPWR _016_ sky130_fd_sc_hd__o21ai_1
X_082_ net49 net48 VGND VGND VPWR VPWR _053_ sky130_fd_sc_hd__nor2_1
X_151_ clknet_2_1__leaf_clk_regs _002_ net50 VGND VGND VPWR VPWR net22 sky130_fd_sc_hd__dfrtp_1
XFILLER_9_41 VGND VGND VPWR VPWR sky130_fd_sc_hd__fill_2
X_117_ _048_ net9 _030_ VGND VGND VPWR VPWR _032_ sky130_fd_sc_hd__mux2_1
XPHY_EDGE_ROW_16_Left_34 VGND VGND VPWR VPWR sky130_fd_sc_hd__decap_3
XFILLER_15_40 VGND VGND VPWR VPWR sky130_fd_sc_hd__fill_1
XPHY_EDGE_ROW_1_Left_19 VGND VGND VPWR VPWR sky130_fd_sc_hd__decap_3
Xoutput4 net4 VGND VGND VPWR VPWR dac_n[1] sky130_fd_sc_hd__clkbuf_1
X_081_ state\[1\] state\[2\] net46 VGND VGND VPWR VPWR _052_ sky130_fd_sc_hd__o21ai_1
XPHY_EDGE_ROW_16_Right_16 VGND VGND VPWR VPWR sky130_fd_sc_hd__decap_3
XFILLER_12_41 VGND VGND VPWR VPWR sky130_fd_sc_hd__decap_3
X_150_ clknet_2_0__leaf_clk_regs _001_ net31 VGND VGND VPWR VPWR net20 sky130_fd_sc_hd__dfrtp_1
XFILLER_3_76 VGND VGND VPWR VPWR sky130_fd_sc_hd__fill_2
XFILLER_9_64 VGND VGND VPWR VPWR sky130_fd_sc_hd__fill_1
X_133_ _049_ _053_ net36 VGND VGND VPWR VPWR _039_ sky130_fd_sc_hd__a21oi_1
XFILLER_0_55 VGND VGND VPWR VPWR sky130_fd_sc_hd__fill_1
XPHY_EDGE_ROW_4_Left_22 VGND VGND VPWR VPWR sky130_fd_sc_hd__decap_3
XFILLER_9_9 VGND VGND VPWR VPWR sky130_fd_sc_hd__decap_3
XFILLER_6_98 VGND VGND VPWR VPWR sky130_fd_sc_hd__decap_3
XFILLER_6_32 VGND VGND VPWR VPWR sky130_fd_sc_hd__fill_2
X_116_ _048_ _030_ VGND VGND VPWR VPWR _031_ sky130_fd_sc_hd__nor2_1
XPHY_EDGE_ROW_2_Right_2 VGND VGND VPWR VPWR sky130_fd_sc_hd__decap_3
XFILLER_7_6 VGND VGND VPWR VPWR sky130_fd_sc_hd__decap_3
Xoutput5 net5 VGND VGND VPWR VPWR dac_n[2] sky130_fd_sc_hd__clkbuf_1
XFILLER_3_99 VGND VGND VPWR VPWR sky130_fd_sc_hd__fill_1
X_132_ net34 _057_ _062_ _034_ VGND VGND VPWR VPWR _015_ sky130_fd_sc_hd__a31o_1
X_080_ state\[0\] state\[1\] VGND VGND VPWR VPWR _051_ sky130_fd_sc_hd__nand2_1
XFILLER_9_76 VGND VGND VPWR VPWR sky130_fd_sc_hd__fill_2
X_115_ net49 net48 state\[3\] net47 VGND VGND VPWR VPWR _030_ sky130_fd_sc_hd__or4b_4
XFILLER_6_22 VGND VGND VPWR VPWR sky130_fd_sc_hd__decap_3
Xoutput6 net6 VGND VGND VPWR VPWR dac_n[3] sky130_fd_sc_hd__clkbuf_1
.ends
