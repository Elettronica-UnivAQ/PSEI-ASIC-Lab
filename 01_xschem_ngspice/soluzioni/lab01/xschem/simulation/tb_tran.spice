** sch_path: /foss/designs/modulo1/lab01/xschem/tb_tran.sch
**.subckt tb_tran
x1 Vdd IN OUT GND inverter
Vin IN GND PULSE(0 1.8 0 100p 100p 4n 8n)
V2 Vdd GND 1.8
**** begin user architecture code

** opencircuitdesign pdks install
.lib /foss/pdks/sky130A/libs.tech/combined/sky130.lib.spice tt

.save all

.control
  tran 10p 20n

  * tpHL: ritardo da IN che sale (50%) a OUT che scende (50%)
  meas tran tpHL TRIG v(IN) VAL=0.9 RISE=1 TARG v(OUT) VAL=0.9 FALL=1

  * tpLH: ritardo da IN che scende (50%) a OUT che sale (50%)
  meas tran tpLH TRIG v(IN) VAL=0.9 FALL=1 TARG v(OUT) VAL=0.9 RISE=1

  write tb_tran.raw
.endc

**** end user architecture code
**.ends

* expanding   symbol:  inverter.sym # of pins=4
** sym_path: /foss/designs/modulo1/lab01/xschem/inverter.sym
** sch_path: /foss/designs/modulo1/lab01/xschem/inverter.sch
.subckt inverter VDD IN OUT GND
*.ipin IN
*.opin OUT
*.iopin VDD
*.iopin GND
XM1 OUT IN GND GND sky130_fd_pr__nfet_01v8 L=0.15 W=1 nf=1 ad=0.29 as=0.29 pd=2.58 ps=2.58 nrd=0.29 nrs=0.29 sa=0 sb=0 sd=0 mult=1
+ m=1
XM2 OUT IN VDD VDD sky130_fd_pr__pfet_01v8 L=0.15 W=2 nf=1 ad=0.58 as=0.58 pd=4.58 ps=4.58 nrd=0.145 nrs=0.145 sa=0 sb=0 sd=0
+ mult=1 m=1
.ends

.GLOBAL GND
.end
