** sch_path: /foss/designs/modulo5/lab01/xschem/tb_passgate_pvt.sch
**.subckt tb_passgate_pvt
Vvdd vdd GND {vdd_param}
x1 Vin GND ctrl_not ctrl vdd Vout passgate
Vvin Vin GND PULSE(0 0.9 100n 1n 1n 800n 1000n)
Vctrl ctrl GND PULSE(0 {vdd_param} 50n 1n 1n 900n 1000n)
Vctrl_not ctrl_not GND PULSE({vdd_param} 0 50n 1n 1n 900n 1000n)
C1 Vout GND 12.8p m=1
R1 Vout GND 1G m=1
**** begin user architecture code

.param vdd_param=1.8
.options savecurrents

.control
  save all
  set appendwrite
  shell rm -f tb_passgate_pvt.raw
  set outfile = pvt_passgate_tt.txt
  echo T_C,VDD_V,t_settle_ns > $outfile

  foreach T_val -40 27 125
    foreach VDD_val 1.62 1.8 1.98
      set t_save   = $T_val
      set vdd_save = $VDD_val
      alterparam vdd_param = $vdd_save
      reset
      set temp = $t_save

      tran 100p 1000n
      meas tran t_settle WHEN v(Vout) = 0.8995 RISE=1 TD=110n
      let t_settle_ns = (t_settle - 100e-9) * 1e9
      echo $t_save,$vdd_save,$&t_settle_ns >> $outfile
      echo T=$t_save VDD=$vdd_save t_settle=$&t_settle_ns ns
      write tb_passgate_pvt.raw v(Vout) v(Vin) v(ctrl) v(ctrl_not)
    end
  end
.endc

.lib /foss/pdks/sky130A/libs.tech/combined/sky130.lib.spice tt
**** end user architecture code
**.ends

* expanding   symbol:  passgate.sym # of pins=6
** sym_path: /foss/designs/modulo5/lab01/xschem/passgate.sym
** sch_path: /foss/designs/modulo5/lab01/xschem/passgate.sch
.subckt passgate Vin gnd !CTRL CTRL Vdd Vout
*.ipin CTRL
*.ipin !CTRL
*.iopin Vin
*.iopin Vout
*.ipin Vdd
*.ipin gnd
XM1 Vin CTRL Vout gnd sky130_fd_pr__nfet_01v8_lvt L=0.15 W=6 nf=1 ad=1.74 as=1.74 pd=12.58 ps=12.58 nrd=0.0483333333333333
+ nrs=0.0483333333333333 sa=0 sb=0 sd=0 mult=1 m=1
XM2 Vin !CTRL Vout Vdd sky130_fd_pr__pfet_01v8_lvt L=0.35 W=12 nf=1 ad=3.48 as=3.48 pd=24.58 ps=24.58 nrd=0.0241666666666667
+ nrs=0.0241666666666667 sa=0 sb=0 sd=0 mult=1 m=1
.ends

.GLOBAL GND
.end
