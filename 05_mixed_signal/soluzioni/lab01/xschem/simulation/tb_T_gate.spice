** sch_path: /foss/designs/modulo5/lab01/xschem/tb_T_gate.sch
**.subckt tb_T_gate
x1 vdd GND Vctrl out Vref T_gate
Vvdd vdd GND 1.8
Vvref Vref GND 0.256
Vctrl Vctrl GND PULSE(0 1.8 100n 1n 1n 50n 100n)
C1 out GND 6.4p m=1
R1 out GND 1G m=1
**** begin user architecture code

** opencircuitdesign pdks install
.lib /foss/pdks/sky130A/libs.tech/combined/sky130.lib.spice tt

.option savecurrents
.control
  save all
  tran 10p 200n
  write tb_T_gate.raw v(out) v(Vctrl)
  plot v(out) v(Vctrl)
.endc

**** end user architecture code
**.ends

* expanding   symbol:  T_gate.sym # of pins=5
** sym_path: /foss/designs/modulo5/lab01/xschem/T_gate.sym
** sch_path: /foss/designs/modulo5/lab01/xschem/T_gate.sch
.subckt T_gate VDD GND Ctrl Vout Vref
*.ipin Ctrl
*.iopin Vout
*.iopin VDD
*.iopin GND
*.iopin Vref
x1 VDD Ctrl net1 GND inverter
XM1 GND net1 Vout GND sky130_fd_pr__nfet_01v8_lvt L=0.15 W=2 nf=1 ad=0.58 as=0.58 pd=4.58 ps=4.58 nrd=0.145 nrs=0.145 sa=0 sb=0
+ sd=0 mult=1 m=1
XM2 GND Ctrl Vout VDD sky130_fd_pr__pfet_01v8_lvt L=0.35 W=4 nf=1 ad=1.16 as=1.16 pd=8.58 ps=8.58 nrd=0.0725 nrs=0.0725 sa=0 sb=0
+ sd=0 mult=1 m=1
XM3 Vref Ctrl Vout GND sky130_fd_pr__nfet_01v8_lvt L=0.15 W=2 nf=1 ad=0.58 as=0.58 pd=4.58 ps=4.58 nrd=0.145 nrs=0.145 sa=0 sb=0
+ sd=0 mult=1 m=1
XM4 Vref net1 Vout VDD sky130_fd_pr__pfet_01v8_lvt L=0.35 W=4 nf=1 ad=1.16 as=1.16 pd=8.58 ps=8.58 nrd=0.0725 nrs=0.0725 sa=0 sb=0
+ sd=0 mult=1 m=1
.ends

* expanding   symbol:  inverter.sym # of pins=4
** sym_path: /foss/designs/modulo5/lab01/xschem/inverter.sym
** sch_path: /foss/designs/modulo5/lab01/xschem/inverter.sch
.subckt inverter VDD IN OUT GND
*.ipin IN
*.opin OUT
*.iopin VDD
*.iopin GND
XM1 OUT IN GND GND sky130_fd_pr__nfet_01v8_lvt L=0.15 W=2 nf=1 ad=0.58 as=0.58 pd=4.58 ps=4.58 nrd=0.145 nrs=0.145 sa=0 sb=0 sd=0
+ mult=1 m=1
XM2 OUT IN VDD VDD sky130_fd_pr__pfet_01v8_lvt L=0.35 W=4 nf=1 ad=1.16 as=1.16 pd=8.58 ps=8.58 nrd=0.0725 nrs=0.0725 sa=0 sb=0
+ sd=0 mult=1 m=1
.ends

.GLOBAL GND
.end
